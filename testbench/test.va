`include "disciplines.vams"

module resistor(p, n);
    electrical p, n;
    parameter real r = 1k;

    analog begin
        V(p,n) <+ r * I(p,n);
    end
endmodule
